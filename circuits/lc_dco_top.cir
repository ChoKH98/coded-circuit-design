* Subthreshold CMOS Cross-Coupled LC-DCO with CAP BANK + Current DAC
* IHP SG13G2 130nm SiGe BiCMOS — Phase 2
*
* Design references:
*   [1] Abbasizadeh 2018 — 260uW subthreshold LC-DCO
*   [2] Okada lab — Synthesizable IL-PLL with LC-DCO
*
* Architecture:
*   CMOS complementary cross-coupled pair (NMOS+PMOS)
*   LC tank: L=2.00nH (larger inductor retune) + C_F + MSB(5b) + LSB(5b)
*   Tail current DAC: same MSB bits control BOTH C and I_tail
*
* Current DAC concept:
*   As MSB increases → f decreases → R_p decreases → I_tail increases
*   → gm×R_p (loop gain) stays roughly constant across tuning range
*   MSB=00000: I_tail≈96uA  → P≈86uW   (same f_max target, lower gm required)
*   MSB=11111: I_tail≈394uA → P≈355uW  (same coarse f target, lower gm required)
*
* VDD=0.9V (subthreshold: below Vthn+|Vthp|=1.035V → gm/ID maximized)

* ============================================================
* PDK Models
* ============================================================
.lib "/home/whqkrel/tools/IHP-Open-PDK/ihp-sg13g2/libs.tech/ngspice/models/cornerMOSlv.lib" mos_tt

* ============================================================
* Ideal switch model (cap bank + current DAC switches)
* Physical layout: NMOS W=50-100um for RF cap switch
*                  NMOS W=2-32um for DC current DAC switch (Ron OK)
* ============================================================
.model SW_IDEAL SW(Ron=0.1 Roff=1Meg Vt=0.5 Vh=0.1)

* ============================================================
* Sub-circuit blocks
* ============================================================
.include '/home/whqkrel/rfic_project/circuits/blocks/cross_coupled_pair.cir'
.include '/home/whqkrel/rfic_project/circuits/blocks/cap_bank_msb.cir'
.include '/home/whqkrel/rfic_project/circuits/blocks/cap_bank_lsb.cir'
.include '/home/whqkrel/rfic_project/circuits/blocks/lc_tank.cir'
.include '/home/whqkrel/rfic_project/circuits/blocks/ptat_ref.cir'
.include '/home/whqkrel/rfic_project/circuits/blocks/tail_current_dac.cir'
.include '/home/whqkrel/rfic_project/circuits/blocks/ldo_tail.cir'

* ============================================================
* Supply
* ============================================================
VDD vdd 0 DC 0.9

* ============================================================
* CAP BANK + Current DAC digital control bits (same word)
*   MSB=00000, LSB=00000 → f_max≈4.42GHz, I_tail≈96uA
*   MSB=11111, LSB=~10111 → f≈2.4GHz,     I_tail≈500uA
* ============================================================
VMSB4 msb4 0 DC 0
VMSB3 msb3 0 DC 0
VMSB2 msb2 0 DC 0
VMSB1 msb1 0 DC 0
VMSB0 msb0 0 DC 0

VLSB4 lsb4 0 DC 0
VLSB3 lsb3 0 DC 0
VLSB2 lsb2 0 DC 0
VLSB1 lsb1 0 DC 0
VLSB0 lsb0 0 DC 0

* ============================================================
* Circuit instantiation
* ============================================================

* LC tank with CAP BANKS
X_tank outp outn msb4 msb3 msb2 msb1 msb0 lsb4 lsb3 lsb2 lsb1 lsb0 lc_tank

* CMOS negative-gm core
X_gm outp outn vdd vs cross_coupled_pair

* LDO tail: physical current source (PMOS VDD→vs, LDO regulated)
X_tail vs vdd msb4 msb3 msb2 msb1 msb0 lsb4 lsb3 lsb2 lsb1 lsb0 ldo_tail
* Ideal fallback: * I_tail vs 0 DC 96u

* ============================================================
* Initial conditions
* ============================================================
.ic V(outp)=0.500 V(outn)=0.300 V(vs)=0.050

* ============================================================
* Transient simulation: 200ns (150-200ns = steady-state window)
* ============================================================
.tran 2p 200n uic

.control
run

echo =============================================
echo   LC-DCO Phase 2 — Current DAC Results
echo =============================================

meas tran v_max max v(outp) from=150n to=200n
meas tran v_min min v(outp) from=150n to=200n
let v_swing = v_max - v_min
echo V_swing [V]:
print v_swing

meas tran i_vdd avg i(VDD) from=150n to=200n
let p_dc_uW = -i_vdd * 0.9 * 1e6
echo P_dc [uW]:
print p_dc_uW

meas tran vs_avg avg v(vs) from=150n to=200n
echo V(vs) avg [V]:
print vs_avg

wrdata /home/whqkrel/rfic_project/results/lc_dco_data.csv v(outp) v(outn) v(vs)
echo Waveform saved.

quit
.endc

.end
